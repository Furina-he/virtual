.subckt mod_dig_pulse VCC GND DIF_IN DIF_G1Y DIF_RC DIF_Q M121_B M121_RC M121_Q M121_NQ M123_B M123_CLR M123_RC M123_Q M123_NQ S14_IN S14_OUT S106_IN S106_OUT OSC_R OSC_C K_CLR params: r_dif=1000 r_121=10000 r_osc=4700 sw_clr=1
* 脉冲整形与单稳态实验箱（SD-14 微分型单稳、SD-15 74LS121/123 单稳、SD-16 74LS14/CD40106 施密特）
Rgnd GND 0 1G
Rvcc_bleed VCC GND 100k
Cdec VCC GND 100n

* ---- 0. 逻辑清零开关 K_CLR ----
RK_HI VCC k_sw {sw_clr > 0.5 ? 100 : 1G}
RK_LO k_sw GND {sw_clr > 0.5 ? 1G : 100}
Bk k_buf GND V=V(k_sw,GND)
Rk_out k_buf K_CLR 50

* ---- 1. SD-14 微分型单稳态触发器（74LS00 双与非门 + 470 nF + 可调 RDIF）----
* 稳态 DIF_IN=H、DIF_RC=L -> DIF_Q=H、DIF_G1Y=L；负脉冲触发 DIF_IN=L -> DIF_G1Y 跳高经 Cd 耦合至 DIF_RC，
* DIF_Q 跳低锁定 G1，随后 Cd 经 RDIF 放电至阈值后恢复稳态，脉宽 tw 与 RDIF·Cd 成正比。
X00 DIF_IN DIF_Q DIF_G1Y DIF_RC VCC DIF_Q GND u00_3 GND GND u00_4 GND GND VCC SN74LS00
Cdif DIF_G1Y DIF_RC 470n
RDIF DIF_RC GND {r_dif}
Rdif_in_pu DIF_IN VCC 100k
Rdif_q DIF_Q GND 10k
Rdif_g1 DIF_G1Y GND 10k

* ---- 2. SD-15 集成单稳态触发器：SN74LS121（不可重触发）与 SN74LS123（可重触发）----
X121 M121_NQ nc121_2 GND GND M121_B M121_Q GND nc121_8 nc121_9 c121_x M121_RC nc121_12 nc121_13 VCC SN74LS121
R121T VCC M121_RC {r_121}
C121T M121_RC c121_x 100n
Rm121q M121_Q GND 10k
Rm121nq M121_NQ GND 10k

Rm123clr_pu M123_CLR VCC 20k
X123 GND M123_B M123_CLR M123_NQ u123_2q c123_2x rc123_2 GND GND GND VCC u123_2nq M123_Q c123_1x M123_RC VCC SN74LS123
R123T VCC M123_RC 15k
C123T M123_RC c123_1x 100n
Rm123q M123_Q GND 10k
Rm123nq M123_NQ GND 10k

* ---- 3. SD-16 集成施密特触发器：SN74LS14 与 CD40106 + RC 多谐振荡网络 ----
X14 S14_IN S14_OUT GND u14_2 GND u14_3 GND u14_4 GND u14_5 GND u14_6 GND VCC SN74LS14
Rs14o S14_OUT GND 10k
X106 S106_IN S106_OUT GND u106_2 GND u106_3 GND u106_4 GND u106_5 GND u106_6 GND VCC CD40106
Rs106o S106_OUT GND 100k
ROSC OSC_R OSC_C {r_osc}
Cosc OSC_C GND 100n
Rosc_leak OSC_C GND 10Meg
.ends mod_dig_pulse

.include "ttl.lib"
.include "cmos.lib"
