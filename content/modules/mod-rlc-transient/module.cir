.subckt mod_rlc_transient RS_1 RS_2 LS_1 LS_2 CS_1 CS_2 BR_AC1 BR_AC2 BR_P FL_OUT BR_N IND_IN IND_1 IND_2 TR_1 TR_2 TC_1 TC_2 params: r_ser=51 sw_filt=0 sw_ind=1 sw_supp=0 r_tau=1000 c_tau=1
* 动态电路与 RLC 综合实验挂箱（原型选型说明 §3.1 #3，服务 DG-13 / DG-14 / DG-17 / DG-19 / DG-20）
*
* ---- 区 1：R / L / C 阻抗频率特性与串联谐振单元（f0 = 5032.9 Hz） ----
RRSER RS_1 RS_2 {r_ser}
RLS_W LS_1 n_ls 5
LLS n_ls LS_2 10m
RCS_ESR CS_1 n_cs 0.2
CCS n_cs CS_2 0.1u
R_cs_bleed CS_1 CS_2 100Meg
R_iso_cs CS_2 0 100Meg
*
* ---- 区 2：1N4007 全波整流桥与无滤波 / 单电容 / π型 LC 滤波单元 ----
DBR1 BR_AC1 BR_P D1N4007
DBR2 BR_AC2 BR_P D1N4007
DBR3 BR_N BR_AC1 D1N4007
DBR4 BR_N BR_AC2 D1N4007
RFILT_C1 BR_P n_fc1 {sw_filt > 0.5 ? 1 : 100Meg}
CFILT1 n_fc1 BR_N 100u
Rbleed_fc1 n_fc1 BR_N 100Meg
RFILT_BYP BR_P FL_OUT {sw_filt > 1.5 ? 100Meg : 1}
RFILT_L BR_P n_fl1 {sw_filt > 1.5 ? 1 : 100Meg}
LFILT n_fl1 n_fl2 0.2
RFILT_LW n_fl2 FL_OUT 20
RFILT_C2 FL_OUT n_fc2 {sw_filt > 1.5 ? 1 : 100Meg}
CFILT2 n_fc2 BR_N 100u
Rbleed_fc2 n_fc2 BR_N 100Meg
RRECT_LOAD FL_OUT BR_N 1k
R_iso_br BR_N 0 100Meg
*
* ---- 区 3：电感自感测定与断电尖峰抑制单元（L = 0.5 H, Rw = 50 Ω） ----
RSW_IND IND_IN IND_1 {sw_ind > 0.5 ? 1 : 500}
RIND_W IND_1 n_ind 50
LIND n_ind IND_2 0.5
* 续流二极管支路（阴极接 IND_1，阳极接 IND_2）
RSUPP_D IND_2 n_sd {sw_supp < 0.5 ? 100Meg : (sw_supp < 1.5 ? 1 : 100Meg)}
DSUPP n_sd IND_1 D1N4007
* RC 吸收支路（100 Ω + 1 µF）
RSUPP_RC IND_1 n_src {sw_supp > 1.5 ? 100 : 100Meg}
CSUPP n_src IND_2 1u
Rbleed_cs n_src IND_2 100Meg
R_iso_ind IND_2 0 100Meg
*
* ---- 区 4：一阶 RC 暂态与微分/积分单元（Rt = 1k/5k/10k, Ct = 0.01µF / 0.1µF） ----
RRTAU TR_1 TR_2 {r_tau}
RCTAU_A TC_1 n_cta 1
CTAU_A n_cta TC_2 0.01u
RCTAU_B TC_1 n_ctb {c_tau > 0.5 ? 1 : 100Meg}
CTAU_B n_ctb TC_2 0.09u
Rbleed_cta n_cta TC_2 100Meg
Rbleed_ctb n_ctb TC_2 100Meg
Rbleed_ct TC_1 TC_2 100Meg
R_iso_tc TC_2 0 100Meg
.ends mod_rlc_transient
.include diodes.lib
