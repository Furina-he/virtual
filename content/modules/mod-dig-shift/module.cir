.subckt mod_dig_shift VCC GND K0 K1 CP_MAN CLK_OUT SH_CLR SH_S0 SH_S1 SH_CP SH_SR SH_SL SH_A SH_B SH_C SH_D SH_QA SH_QB SH_QC SH_QD SH_RING_FB params: sw_k0=1 sw_k1=1 cp_btn=0 clk_rate=2 par_data=10
* 双向移位寄存器实验箱（SD-08 74LS194，兼供 B6 SD-19 环形计数节拍发生器）
Rgnd GND 0 1G
Rvcc_bleed VCC GND 100k
Cdec VCC GND 100n

* ---- 1. 逻辑开关 K0/K1、手动单次脉冲 CP_MAN 与连续脉冲 CLK_OUT ----
RK0_HI VCC k0_sw {sw_k0 > 0.5 ? 100 : 1G}
RK0_LO k0_sw GND {sw_k0 > 0.5 ? 1G : 100}
Bk0 k0_buf GND V=V(k0_sw,GND)
Rk0_out k0_buf K0 50

RK1_HI VCC k1_sw {sw_k1 > 0.5 ? 100 : 1G}
RK1_LO k1_sw GND {sw_k1 > 0.5 ? 1G : 100}
Bk1 k1_buf GND V=V(k1_sw,GND)
Rk1_out k1_buf K1 50

RCP_HI VCC cp_sw {cp_btn > 0.5 ? 100 : 1G}
RCP_LO cp_sw GND {cp_btn > 0.5 ? 1G : 100}
Bcp cp_buf GND V=V(cp_sw,GND)
Rcp_out cp_buf CP_MAN 50

Vclk1 clk1_raw GND PULSE(0 1 0.475 10u 10u 0.5 1.0)
Vclk2 clk2_raw GND PULSE(0 1 0.225 10u 10u 0.25 0.5)
Vclk5 clk5_raw GND PULSE(0 1 0.075 10u 10u 0.1 0.2)
Vclk10 clk10_raw GND PULSE(0 1 0.025 10u 10u 0.05 0.1)
RCLK1 clk1_raw clk_mix {clk_rate < 1.5 ? 10 : 1G}
RCLK2 clk2_raw clk_mix {clk_rate >= 1.5 && clk_rate < 3.5 ? 10 : 1G}
RCLK5 clk5_raw clk_mix {clk_rate >= 3.5 && clk_rate < 7.5 ? 10 : 1G}
RCLK10 clk10_raw clk_mix {clk_rate >= 7.5 ? 10 : 1G}
Rclk_load clk_mix GND 100k
Bclk_buf clk_buf GND V=V(clk_mix,GND)*max(V(VCC,GND),0)
Rclk_out clk_buf CLK_OUT 50

* ---- 2. 并行预置数据（1 kΩ 软驱动 SH_A~SH_D，外部接 VCC/GND 可直接覆盖）----
RPA_HI VCC SH_A {(floor(par_data + 0.5) - 2*floor((floor(par_data + 0.5))/2)) > 0.5 ? 1000 : 1G}
RPA_LO SH_A GND {(floor(par_data + 0.5) - 2*floor((floor(par_data + 0.5))/2)) > 0.5 ? 1G : 1000}
RPB_HI VCC SH_B {(floor(floor(par_data + 0.5)/2) - 2*floor(floor(par_data + 0.5)/4)) > 0.5 ? 1000 : 1G}
RPB_LO SH_B GND {(floor(floor(par_data + 0.5)/2) - 2*floor(floor(par_data + 0.5)/4)) > 0.5 ? 1G : 1000}
RPC_HI VCC SH_C {(floor(floor(par_data + 0.5)/4) - 2*floor(floor(par_data + 0.5)/8)) > 0.5 ? 1000 : 1G}
RPC_LO SH_C GND {(floor(floor(par_data + 0.5)/4) - 2*floor(floor(par_data + 0.5)/8)) > 0.5 ? 1G : 1000}
RPD_HI VCC SH_D {floor(par_data + 0.5) >= 8 ? 1000 : 1G}
RPD_LO SH_D GND {floor(par_data + 0.5) >= 8 ? 1G : 1000}

* ---- 3. 74LS194 双向移位寄存器（1 ms 上电清零确保初态确定）----
Vpor por_n GND PULSE(0 1 1m 10u 10u 1e6 2e6)
Rpor por_n GND 100k
Rshclr_pu SH_CLR VCC 20k
Bshclr sh_clr_int GND V=min(V(SH_CLR,GND),V(por_n,GND)*max(V(VCC,GND),0))
X194 sh_clr_int SH_SR SH_A SH_B SH_C SH_D SH_SL GND SH_S0 SH_S1 SH_CP SH_QD SH_QC SH_QB SH_QA VCC SN74LS194
Rqa SH_QA GND 10k
Rqb SH_QB GND 10k
Rqc SH_QC GND 10k
Rqd SH_QD GND 10k

* ---- 4. 自启动四拍环形计数器反馈门 SH_RING_FB = ~(QA | QB | QC) ----
Xfb_or SH_QA SH_QB ab_or ab_or SH_QC abc_or GND u32_3 GND GND u32_4 GND GND VCC SN74LS32
Xfb_inv abc_or SH_RING_FB GND u04_2 GND u04_3 GND u04_4 GND u04_5 GND u04_6 GND VCC SN74LS04
Rrfb SH_RING_FB GND 10k
.ends mod_dig_shift

.include "ttl.lib"
